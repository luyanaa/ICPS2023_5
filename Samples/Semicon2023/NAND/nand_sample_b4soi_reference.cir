* B4SOI LVS reference migrated from lvs_work/nand_sample_reference.cir.txt.
* M terminals use D G S E; E is the common global substrate node SUB.
* The shipped GDS is foundry-mask numbered: a 14 um TiN gate window (the 10 um
* drawing gate plus 2 um per end) over a 10 um physical dopant gap.
* This reference preserves that measured geometry; it is not the native PCell L=6 um case.
.GLOBAL SUB
.GLOBAL 0
XX1 NC_01 NC_02 N001 0 NC_03 NAND_MIN
M1 NC_04 NC_05 NC_06 SUB NCH L=10.0U W=10.0U
M2 NC_08 NC_09 NC_10 SUB NCH L=10.0U W=10.0U
M3 NC_12 NC_13 NC_14 SUB NCH L=10.0U W=10.0U
M4 NC_16 NC_17 NC_18 SUB NCH L=10.0U W=10.0U
M5 NC_20 NC_21 NC_22 SUB NCH L=10.0U W=10.0U
M6 NC_24 NC_25 NC_26 SUB NCH L=10.0U W=10.0U
M7 NC_28 NC_29 NC_30 SUB NCH L=10.0U W=10.0U
M8 NC_32 NC_33 NC_34 SUB NCH L=10.0U W=10.0U
M9 NC_36 NC_37 NC_38 SUB NCH L=10.0U W=10.0U
M10 NC_40 NC_41 NC_42 SUB NCH L=10.0U W=10.0U
M11 NC_44 NC_45 NC_46 SUB NCH L=10.0U W=10.0U
M12 NC_48 NC_49 NC_50 SUB NCH L=10.0U W=10.0U
M14 NC_52 NC_53 NC_54 SUB PCH L=10.0U W=40U
M15 NC_56 NC_57 NC_58 SUB PCH L=10.0U W=40U
M16 NC_60 NC_61 NC_62 SUB PCH L=10.0U W=40U
M17 NC_64 NC_65 NC_66 SUB PCH L=10.0U W=40U
M18 NC_68 NC_69 NC_70 SUB PCH L=10.0U W=40U
M19 NC_72 NC_73 NC_74 SUB PCH L=10.0U W=40U
M20 NC_76 NC_77 NC_78 SUB PCH L=10.0U W=40U
M21 NC_80 NC_81 NC_82 SUB PCH L=10.0U W=40U
M22 NC_84 NC_85 NC_86 SUB PCH L=10.0U W=40U
M23 NC_88 NC_89 NC_90 SUB PCH L=10.0U W=40U
M24 NC_92 NC_93 NC_94 SUB PCH L=10.0U W=40U
M25 NC_96 NC_97 NC_98 SUB PCH L=10.0U W=40U
M13 NC_100 NC_101 NC_102 SUB NCH L=10.0U W=10.0U
M26 NC_104 NC_105 NC_106 SUB NCH L=10.0U W=10.0U
M27 NC_108 NC_109 NC_110 SUB PCH L=10.0U W=40U
M28 NC_112 NC_113 NC_114 SUB PCH L=10.0U W=40U
*
.SUBCKT NAND_MIN A B VDD VSS Y
M1 Y B VDD SUB PCH L=10.0U W=40.0U
M2 Y A VDD SUB PCH L=10.0U W=40.0U
M3 Y A N001 SUB NCH L=10.0U W=10.0U
M4 N001 B VSS SUB NCH L=10.0U W=10.0U
.ENDS NAND_MIN
.END
