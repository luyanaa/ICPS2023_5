* ICPS2023_5 canonical 1M standard-cell reference
.GLOBAL SUB
.SUBCKT INV_X1 A Y VDD VSS
M_INV_P VDD A Y SUB pch W=2.4e-05 L=6e-06
M_INV_N Y A VSS SUB nch W=2.4e-05 L=6e-06
.ENDS INV_X1
.SUBCKT BUF_X1 A Y VDD VSS
M_I0_P VDD A N SUB pch W=2.4e-05 L=6e-06
M_I0_N N A VSS SUB nch W=2.4e-05 L=6e-06
M_I1_P VDD N Y SUB pch W=2.4e-05 L=6e-06
M_I1_N Y N VSS SUB nch W=2.4e-05 L=6e-06
.ENDS BUF_X1
.SUBCKT NAND2_X1 A B Y VDD VSS
M_NAND_P0 VDD A Y SUB pch W=2.4e-05 L=6e-06
M_NAND_P1 VDD B Y SUB pch W=2.4e-05 L=6e-06
M_NAND_N0 NAND_NINT0 B VSS SUB nch W=2.4e-05 L=6e-06
M_NAND_N1 Y A NAND_NINT0 SUB nch W=2.4e-05 L=6e-06
.ENDS NAND2_X1
.SUBCKT NAND2_BA_X1 B A Y VDD VSS
M_NAND_P0 VDD B Y SUB pch W=2.4e-05 L=6e-06
M_NAND_P1 VDD A Y SUB pch W=2.4e-05 L=6e-06
M_NAND_N0 NAND_NINT0 A VSS SUB nch W=2.4e-05 L=6e-06
M_NAND_N1 Y B NAND_NINT0 SUB nch W=2.4e-05 L=6e-06
.ENDS NAND2_BA_X1
.SUBCKT NAND3_X1 A B C Y VDD VSS
M_NAND_P0 VDD A Y SUB pch W=2.4e-05 L=6e-06
M_NAND_P1 VDD B Y SUB pch W=2.4e-05 L=6e-06
M_NAND_P2 VDD C Y SUB pch W=2.4e-05 L=6e-06
M_NAND_N0 NAND_NINT0 C VSS SUB nch W=2.4e-05 L=6e-06
M_NAND_N1 NAND_NINT1 B NAND_NINT0 SUB nch W=2.4e-05 L=6e-06
M_NAND_N2 Y A NAND_NINT1 SUB nch W=2.4e-05 L=6e-06
.ENDS NAND3_X1
.SUBCKT NOR2_X1 A B Y VDD VSS
M_NOR_P0 NOR_PINT0 A Y SUB pch W=2.4e-05 L=6e-06
M_NOR_P1 VDD B NOR_PINT0 SUB pch W=2.4e-05 L=6e-06
M_NOR_N0 Y A VSS SUB nch W=2.4e-05 L=6e-06
M_NOR_N1 Y B VSS SUB nch W=2.4e-05 L=6e-06
.ENDS NOR2_X1
.SUBCKT NOR2_BA_X1 B A Y VDD VSS
M_NOR_P0 NOR_PINT0 B Y SUB pch W=2.4e-05 L=6e-06
M_NOR_P1 VDD A NOR_PINT0 SUB pch W=2.4e-05 L=6e-06
M_NOR_N0 Y B VSS SUB nch W=2.4e-05 L=6e-06
M_NOR_N1 Y A VSS SUB nch W=2.4e-05 L=6e-06
.ENDS NOR2_BA_X1
.SUBCKT NOR3_X1 A B C Y VDD VSS
M_NOR_P0 NOR_PINT0 A Y SUB pch W=2.4e-05 L=6e-06
M_NOR_P1 NOR_PINT1 B NOR_PINT0 SUB pch W=2.4e-05 L=6e-06
M_NOR_P2 VDD C NOR_PINT1 SUB pch W=2.4e-05 L=6e-06
M_NOR_N0 Y A VSS SUB nch W=2.4e-05 L=6e-06
M_NOR_N1 Y B VSS SUB nch W=2.4e-05 L=6e-06
M_NOR_N2 Y C VSS SUB nch W=2.4e-05 L=6e-06
.ENDS NOR3_X1
.SUBCKT AOI21_X1 A B C Y VDD VSS
M_AOI_PC VDD C AOI_PINT SUB pch W=2.4e-05 L=6e-06
M_AOI_PA AOI_PINT A Y SUB pch W=2.4e-05 L=6e-06
M_AOI_PB AOI_PINT B Y SUB pch W=2.4e-05 L=6e-06
M_AOI_NA Y A AOI_NINT SUB nch W=2.4e-05 L=6e-06
M_AOI_NB AOI_NINT B VSS SUB nch W=2.4e-05 L=6e-06
M_AOI_NC Y C VSS SUB nch W=2.4e-05 L=6e-06
.ENDS AOI21_X1
.SUBCKT OAI21_X1 A B C Y VDD VSS
M_OAI_PC VDD C Y SUB pch W=2.4e-05 L=6e-06
M_OAI_PA Y A OAI_PINT SUB pch W=2.4e-05 L=6e-06
M_OAI_PB OAI_PINT B VDD SUB pch W=2.4e-05 L=6e-06
M_OAI_NC Y C OAI_NINT SUB nch W=2.4e-05 L=6e-06
M_OAI_NA OAI_NINT A VSS SUB nch W=2.4e-05 L=6e-06
M_OAI_NB OAI_NINT B VSS SUB nch W=2.4e-05 L=6e-06
.ENDS OAI21_X1
.SUBCKT AOI22_X1 A B C D Y VDD VSS
M_AOI_PA VDD A AOI_PINT SUB pch W=2.4e-05 L=6e-06
M_AOI_PB VDD B AOI_PINT SUB pch W=2.4e-05 L=6e-06
M_AOI_PC AOI_PINT C Y SUB pch W=2.4e-05 L=6e-06
M_AOI_PD AOI_PINT D Y SUB pch W=2.4e-05 L=6e-06
M_AOI_NA Y A AOI_NAB SUB nch W=2.4e-05 L=6e-06
M_AOI_NB AOI_NAB B VSS SUB nch W=2.4e-05 L=6e-06
M_AOI_NC Y C AOI_NCD SUB nch W=2.4e-05 L=6e-06
M_AOI_ND AOI_NCD D VSS SUB nch W=2.4e-05 L=6e-06
.ENDS AOI22_X1
.SUBCKT OAI22_X1 A B C D Y VDD VSS
M_OAI_PA VDD A OAI_PAB SUB pch W=2.4e-05 L=6e-06
M_OAI_PB OAI_PAB B Y SUB pch W=2.4e-05 L=6e-06
M_OAI_PC VDD C OAI_PCD SUB pch W=2.4e-05 L=6e-06
M_OAI_PD OAI_PCD D Y SUB pch W=2.4e-05 L=6e-06
M_OAI_NA Y A OAI_NINT SUB nch W=2.4e-05 L=6e-06
M_OAI_NB Y B OAI_NINT SUB nch W=2.4e-05 L=6e-06
M_OAI_NC OAI_NINT C VSS SUB nch W=2.4e-05 L=6e-06
M_OAI_ND OAI_NINT D VSS SUB nch W=2.4e-05 L=6e-06
.ENDS OAI22_X1
.SUBCKT AND2_X1 A B Y VDD VSS
M_N_P0 VDD A N SUB pch W=2.4e-05 L=6e-06
M_N_P1 VDD B N SUB pch W=2.4e-05 L=6e-06
M_N_N0 N_NINT0 B VSS SUB nch W=2.4e-05 L=6e-06
M_N_N1 N A N_NINT0 SUB nch W=2.4e-05 L=6e-06
M_I_P VDD N Y SUB pch W=2.4e-05 L=6e-06
M_I_N Y N VSS SUB nch W=2.4e-05 L=6e-06
.ENDS AND2_X1
.SUBCKT OR2_X1 A B Y VDD VSS
M_N_P0 N_PINT0 A N SUB pch W=2.4e-05 L=6e-06
M_N_P1 VDD B N_PINT0 SUB pch W=2.4e-05 L=6e-06
M_N_N0 N A VSS SUB nch W=2.4e-05 L=6e-06
M_N_N1 N B VSS SUB nch W=2.4e-05 L=6e-06
M_I_P VDD N Y SUB pch W=2.4e-05 L=6e-06
M_I_N Y N VSS SUB nch W=2.4e-05 L=6e-06
.ENDS OR2_X1
.SUBCKT XOR2_X1 A B Y VDD VSS
M_XOR_IA_P VDD A XOR_NA SUB pch W=2.4e-05 L=6e-06
M_XOR_IA_N XOR_NA A VSS SUB nch W=2.4e-05 L=6e-06
M_XOR_IB_P VDD B XOR_NB SUB pch W=2.4e-05 L=6e-06
M_XOR_IB_N XOR_NB B VSS SUB nch W=2.4e-05 L=6e-06
M_XOR_PA VDD A XOR_P0 SUB pch W=2.4e-05 L=6e-06
M_XOR_PNB XOR_P0 XOR_NB Y SUB pch W=2.4e-05 L=6e-06
M_XOR_PNA VDD XOR_NA XOR_P1 SUB pch W=2.4e-05 L=6e-06
M_XOR_PB XOR_P1 B Y SUB pch W=2.4e-05 L=6e-06
M_XOR_NA Y A XOR_N0 SUB nch W=2.4e-05 L=6e-06
M_XOR_NB XOR_N0 B VSS SUB nch W=2.4e-05 L=6e-06
M_XOR_NNA Y XOR_NA XOR_N1 SUB nch W=2.4e-05 L=6e-06
M_XOR_NNB XOR_N1 XOR_NB VSS SUB nch W=2.4e-05 L=6e-06
.ENDS XOR2_X1
.SUBCKT XNOR2_X1 A B Y VDD VSS
M_XNOR_IA_P VDD A XNOR_NA SUB pch W=2.4e-05 L=6e-06
M_XNOR_IA_N XNOR_NA A VSS SUB nch W=2.4e-05 L=6e-06
M_XNOR_IB_P VDD B XNOR_NB SUB pch W=2.4e-05 L=6e-06
M_XNOR_IB_N XNOR_NB B VSS SUB nch W=2.4e-05 L=6e-06
M_XNOR_PA VDD A XNOR_P0 SUB pch W=2.4e-05 L=6e-06
M_XNOR_PB XNOR_P0 B Y SUB pch W=2.4e-05 L=6e-06
M_XNOR_PNA VDD XNOR_NA XNOR_P1 SUB pch W=2.4e-05 L=6e-06
M_XNOR_PNB XNOR_P1 XNOR_NB Y SUB pch W=2.4e-05 L=6e-06
M_XNOR_NA Y A XNOR_N0 SUB nch W=2.4e-05 L=6e-06
M_XNOR_NB XNOR_N0 XNOR_NB VSS SUB nch W=2.4e-05 L=6e-06
M_XNOR_NNA Y XNOR_NA XNOR_N1 SUB nch W=2.4e-05 L=6e-06
M_XNOR_NNB XNOR_N1 B VSS SUB nch W=2.4e-05 L=6e-06
.ENDS XNOR2_X1
.SUBCKT MUX2_TG6T_X1 A B S Y VDD VSS
MUX_SELINV_P VDD S MUX_NS SUB pch W=2.4e-05 L=6e-06
MUX_SELINV_N MUX_NS S VSS SUB nch W=2.4e-05 L=6e-06
MUX_A_N A S Y SUB nch W=2.4e-05 L=6e-06
MUX_A_P A MUX_NS Y SUB pch W=2.4e-05 L=6e-06
MUX_B_N B MUX_NS Y SUB nch W=2.4e-05 L=6e-06
MUX_B_P B S Y SUB pch W=2.4e-05 L=6e-06
.ENDS MUX2_TG6T_X1
.SUBCKT MUX2_STATIC_X1 A B S Y VDD VSS
MUX_SELINV_P VDD S MUX_NS SUB pch W=2.4e-05 L=6e-06
MUX_SELINV_N MUX_NS S VSS SUB nch W=2.4e-05 L=6e-06
MUX_N0_P0 VDD A MUX_T0 SUB pch W=2.4e-05 L=6e-06
MUX_N0_P1 VDD S MUX_T0 SUB pch W=2.4e-05 L=6e-06
MUX_N0_N0 MUX_N0_NINT0 S VSS SUB nch W=2.4e-05 L=6e-06
MUX_N0_N1 MUX_T0 A MUX_N0_NINT0 SUB nch W=2.4e-05 L=6e-06
MUX_N1_P0 VDD B MUX_T1 SUB pch W=2.4e-05 L=6e-06
MUX_N1_P1 VDD MUX_NS MUX_T1 SUB pch W=2.4e-05 L=6e-06
MUX_N1_N0 MUX_N1_NINT0 MUX_NS VSS SUB nch W=2.4e-05 L=6e-06
MUX_N1_N1 MUX_T1 B MUX_N1_NINT0 SUB nch W=2.4e-05 L=6e-06
MUX_N2_P0 VDD MUX_T0 Y SUB pch W=2.4e-05 L=6e-06
MUX_N2_P1 VDD MUX_T1 Y SUB pch W=2.4e-05 L=6e-06
MUX_N2_N0 MUX_N2_NINT0 MUX_T1 VSS SUB nch W=2.4e-05 L=6e-06
MUX_N2_N1 Y MUX_T0 MUX_N2_NINT0 SUB nch W=2.4e-05 L=6e-06
.ENDS MUX2_STATIC_X1
.SUBCKT MUX4_TG_X1 A B C D S0 S1 Y VDD VSS
M0_SELINV_P VDD S0 M0_NS SUB pch W=2.4e-05 L=6e-06
M0_SELINV_N M0_NS S0 VSS SUB nch W=2.4e-05 L=6e-06
M0_A_N A S0 N0 SUB nch W=2.4e-05 L=6e-06
M0_A_P A M0_NS N0 SUB pch W=2.4e-05 L=6e-06
M0_B_N B M0_NS N0 SUB nch W=2.4e-05 L=6e-06
M0_B_P B S0 N0 SUB pch W=2.4e-05 L=6e-06
M1_SELINV_P VDD S0 M1_NS SUB pch W=2.4e-05 L=6e-06
M1_SELINV_N M1_NS S0 VSS SUB nch W=2.4e-05 L=6e-06
M1_A_N C S0 N1 SUB nch W=2.4e-05 L=6e-06
M1_A_P C M1_NS N1 SUB pch W=2.4e-05 L=6e-06
M1_B_N D M1_NS N1 SUB nch W=2.4e-05 L=6e-06
M1_B_P D S0 N1 SUB pch W=2.4e-05 L=6e-06
M2_SELINV_P VDD S1 M2_NS SUB pch W=2.4e-05 L=6e-06
M2_SELINV_N M2_NS S1 VSS SUB nch W=2.4e-05 L=6e-06
M2_A_N N0 S1 Y SUB nch W=2.4e-05 L=6e-06
M2_A_P N0 M2_NS Y SUB pch W=2.4e-05 L=6e-06
M2_B_N N1 M2_NS Y SUB nch W=2.4e-05 L=6e-06
M2_B_P N1 S1 Y SUB pch W=2.4e-05 L=6e-06
.ENDS MUX4_TG_X1
.SUBCKT MUX4_STATIC_X1 A B C D S0 S1 Y VDD VSS
M0_SELINV_P VDD S0 M0_NS SUB pch W=2.4e-05 L=6e-06
M0_SELINV_N M0_NS S0 VSS SUB nch W=2.4e-05 L=6e-06
M0_N0_P0 VDD A M0_T0 SUB pch W=2.4e-05 L=6e-06
M0_N0_P1 VDD S0 M0_T0 SUB pch W=2.4e-05 L=6e-06
M0_N0_N0 M0_N0_NINT0 S0 VSS SUB nch W=2.4e-05 L=6e-06
M0_N0_N1 M0_T0 A M0_N0_NINT0 SUB nch W=2.4e-05 L=6e-06
M0_N1_P0 VDD B M0_T1 SUB pch W=2.4e-05 L=6e-06
M0_N1_P1 VDD M0_NS M0_T1 SUB pch W=2.4e-05 L=6e-06
M0_N1_N0 M0_N1_NINT0 M0_NS VSS SUB nch W=2.4e-05 L=6e-06
M0_N1_N1 M0_T1 B M0_N1_NINT0 SUB nch W=2.4e-05 L=6e-06
M0_N2_P0 VDD M0_T0 N0 SUB pch W=2.4e-05 L=6e-06
M0_N2_P1 VDD M0_T1 N0 SUB pch W=2.4e-05 L=6e-06
M0_N2_N0 M0_N2_NINT0 M0_T1 VSS SUB nch W=2.4e-05 L=6e-06
M0_N2_N1 N0 M0_T0 M0_N2_NINT0 SUB nch W=2.4e-05 L=6e-06
M1_SELINV_P VDD S0 M1_NS SUB pch W=2.4e-05 L=6e-06
M1_SELINV_N M1_NS S0 VSS SUB nch W=2.4e-05 L=6e-06
M1_N0_P0 VDD C M1_T0 SUB pch W=2.4e-05 L=6e-06
M1_N0_P1 VDD S0 M1_T0 SUB pch W=2.4e-05 L=6e-06
M1_N0_N0 M1_N0_NINT0 S0 VSS SUB nch W=2.4e-05 L=6e-06
M1_N0_N1 M1_T0 C M1_N0_NINT0 SUB nch W=2.4e-05 L=6e-06
M1_N1_P0 VDD D M1_T1 SUB pch W=2.4e-05 L=6e-06
M1_N1_P1 VDD M1_NS M1_T1 SUB pch W=2.4e-05 L=6e-06
M1_N1_N0 M1_N1_NINT0 M1_NS VSS SUB nch W=2.4e-05 L=6e-06
M1_N1_N1 M1_T1 D M1_N1_NINT0 SUB nch W=2.4e-05 L=6e-06
M1_N2_P0 VDD M1_T0 N1 SUB pch W=2.4e-05 L=6e-06
M1_N2_P1 VDD M1_T1 N1 SUB pch W=2.4e-05 L=6e-06
M1_N2_N0 M1_N2_NINT0 M1_T1 VSS SUB nch W=2.4e-05 L=6e-06
M1_N2_N1 N1 M1_T0 M1_N2_NINT0 SUB nch W=2.4e-05 L=6e-06
M2_SELINV_P VDD S1 M2_NS SUB pch W=2.4e-05 L=6e-06
M2_SELINV_N M2_NS S1 VSS SUB nch W=2.4e-05 L=6e-06
M2_N0_P0 VDD N0 M2_T0 SUB pch W=2.4e-05 L=6e-06
M2_N0_P1 VDD S1 M2_T0 SUB pch W=2.4e-05 L=6e-06
M2_N0_N0 M2_N0_NINT0 S1 VSS SUB nch W=2.4e-05 L=6e-06
M2_N0_N1 M2_T0 N0 M2_N0_NINT0 SUB nch W=2.4e-05 L=6e-06
M2_N1_P0 VDD N1 M2_T1 SUB pch W=2.4e-05 L=6e-06
M2_N1_P1 VDD M2_NS M2_T1 SUB pch W=2.4e-05 L=6e-06
M2_N1_N0 M2_N1_NINT0 M2_NS VSS SUB nch W=2.4e-05 L=6e-06
M2_N1_N1 M2_T1 N1 M2_N1_NINT0 SUB nch W=2.4e-05 L=6e-06
M2_N2_P0 VDD M2_T0 Y SUB pch W=2.4e-05 L=6e-06
M2_N2_P1 VDD M2_T1 Y SUB pch W=2.4e-05 L=6e-06
M2_N2_N0 M2_N2_NINT0 M2_T1 VSS SUB nch W=2.4e-05 L=6e-06
M2_N2_N1 Y M2_T0 M2_N2_NINT0 SUB nch W=2.4e-05 L=6e-06
.ENDS MUX4_STATIC_X1
.SUBCKT HA_X1 A B SUM COUT VDD VSS
M_SUM_IA_P VDD A SUM_NA SUB pch W=2.4e-05 L=6e-06
M_SUM_IA_N SUM_NA A VSS SUB nch W=2.4e-05 L=6e-06
M_SUM_IB_P VDD B SUM_NB SUB pch W=2.4e-05 L=6e-06
M_SUM_IB_N SUM_NB B VSS SUB nch W=2.4e-05 L=6e-06
M_SUM_PA VDD A SUM_P0 SUB pch W=2.4e-05 L=6e-06
M_SUM_PNB SUM_P0 SUM_NB SUM SUB pch W=2.4e-05 L=6e-06
M_SUM_PNA VDD SUM_NA SUM_P1 SUB pch W=2.4e-05 L=6e-06
M_SUM_PB SUM_P1 B SUM SUB pch W=2.4e-05 L=6e-06
M_SUM_NA SUM A SUM_N0 SUB nch W=2.4e-05 L=6e-06
M_SUM_NB SUM_N0 B VSS SUB nch W=2.4e-05 L=6e-06
M_SUM_NNA SUM SUM_NA SUM_N1 SUB nch W=2.4e-05 L=6e-06
M_SUM_NNB SUM_N1 SUM_NB VSS SUB nch W=2.4e-05 L=6e-06
M_CARRY_P0 VDD A NC SUB pch W=2.4e-05 L=6e-06
M_CARRY_P1 VDD B NC SUB pch W=2.4e-05 L=6e-06
M_CARRY_N0 CARRY_NINT0 B VSS SUB nch W=2.4e-05 L=6e-06
M_CARRY_N1 NC A CARRY_NINT0 SUB nch W=2.4e-05 L=6e-06
M_CARRYI_P VDD NC COUT SUB pch W=2.4e-05 L=6e-06
M_CARRYI_N COUT NC VSS SUB nch W=2.4e-05 L=6e-06
.ENDS HA_X1
.SUBCKT FA_X1 A B CIN SUM COUT VDD VSS
M_X0_IA_P VDD A X0_NA SUB pch W=2.4e-05 L=6e-06
M_X0_IA_N X0_NA A VSS SUB nch W=2.4e-05 L=6e-06
M_X0_IB_P VDD B X0_NB SUB pch W=2.4e-05 L=6e-06
M_X0_IB_N X0_NB B VSS SUB nch W=2.4e-05 L=6e-06
M_X0_PA VDD A X0_P0 SUB pch W=2.4e-05 L=6e-06
M_X0_PNB X0_P0 X0_NB XAB SUB pch W=2.4e-05 L=6e-06
M_X0_PNA VDD X0_NA X0_P1 SUB pch W=2.4e-05 L=6e-06
M_X0_PB X0_P1 B XAB SUB pch W=2.4e-05 L=6e-06
M_X0_NA XAB A X0_N0 SUB nch W=2.4e-05 L=6e-06
M_X0_NB X0_N0 B VSS SUB nch W=2.4e-05 L=6e-06
M_X0_NNA XAB X0_NA X0_N1 SUB nch W=2.4e-05 L=6e-06
M_X0_NNB X0_N1 X0_NB VSS SUB nch W=2.4e-05 L=6e-06
M_X1_IA_P VDD XAB X1_NA SUB pch W=2.4e-05 L=6e-06
M_X1_IA_N X1_NA XAB VSS SUB nch W=2.4e-05 L=6e-06
M_X1_IB_P VDD CIN X1_NB SUB pch W=2.4e-05 L=6e-06
M_X1_IB_N X1_NB CIN VSS SUB nch W=2.4e-05 L=6e-06
M_X1_PA VDD XAB X1_P0 SUB pch W=2.4e-05 L=6e-06
M_X1_PNB X1_P0 X1_NB SUM SUB pch W=2.4e-05 L=6e-06
M_X1_PNA VDD X1_NA X1_P1 SUB pch W=2.4e-05 L=6e-06
M_X1_PB X1_P1 CIN SUM SUB pch W=2.4e-05 L=6e-06
M_X1_NA SUM XAB X1_N0 SUB nch W=2.4e-05 L=6e-06
M_X1_NB X1_N0 CIN VSS SUB nch W=2.4e-05 L=6e-06
M_X1_NNA SUM X1_NA X1_N1 SUB nch W=2.4e-05 L=6e-06
M_X1_NNB X1_N1 X1_NB VSS SUB nch W=2.4e-05 L=6e-06
M_C0_P0 VDD A N0 SUB pch W=2.4e-05 L=6e-06
M_C0_P1 VDD B N0 SUB pch W=2.4e-05 L=6e-06
M_C0_N0 C0_NINT0 B VSS SUB nch W=2.4e-05 L=6e-06
M_C0_N1 N0 A C0_NINT0 SUB nch W=2.4e-05 L=6e-06
M_C1_P0 VDD CIN N1 SUB pch W=2.4e-05 L=6e-06
M_C1_P1 VDD XAB N1 SUB pch W=2.4e-05 L=6e-06
M_C1_N0 C1_NINT0 XAB VSS SUB nch W=2.4e-05 L=6e-06
M_C1_N1 N1 CIN C1_NINT0 SUB nch W=2.4e-05 L=6e-06
M_CO_P0 VDD N0 COUT SUB pch W=2.4e-05 L=6e-06
M_CO_P1 VDD N1 COUT SUB pch W=2.4e-05 L=6e-06
M_CO_N0 CO_NINT0 N1 VSS SUB nch W=2.4e-05 L=6e-06
M_CO_N1 COUT N0 CO_NINT0 SUB nch W=2.4e-05 L=6e-06
.ENDS FA_X1
.SUBCKT LATCH_TG_X1 D CLK Q VDD VSS
M_LATCH_CLKINV_P VDD CLK LATCH_NCLK SUB pch W=2.4e-05 L=6e-06
M_LATCH_CLKINV_N LATCH_NCLK CLK VSS SUB nch W=2.4e-05 L=6e-06
M_LATCH_IN_N D CLK LATCH_N1 SUB nch W=2.4e-05 L=6e-06
M_LATCH_IN_P D LATCH_NCLK LATCH_N1 SUB pch W=2.4e-05 L=6e-06
M_LATCH_INV0_P VDD LATCH_N1 LATCH_N2 SUB pch W=2.4e-05 L=6e-06
M_LATCH_INV0_N LATCH_N2 LATCH_N1 VSS SUB nch W=2.4e-05 L=6e-06
M_LATCH_INV1_P VDD LATCH_N2 Q SUB pch W=2.4e-05 L=6e-06
M_LATCH_INV1_N Q LATCH_N2 VSS SUB nch W=2.4e-05 L=6e-06
M_LATCH_FB_N Q LATCH_NCLK LATCH_N1 SUB nch W=2.4e-05 L=6e-06
M_LATCH_FB_P Q CLK LATCH_N1 SUB pch W=2.4e-05 L=6e-06
.ENDS LATCH_TG_X1
.SUBCKT LATCH_GATE_X1 D CLK Q VDD VSS
M_LATCH_DINV_P VDD D LATCH_ND SUB pch W=2.4e-05 L=6e-06
M_LATCH_DINV_N LATCH_ND D VSS SUB nch W=2.4e-05 L=6e-06
M_LATCH_SET_P0 VDD D LATCH_SBAR SUB pch W=2.4e-05 L=6e-06
M_LATCH_SET_P1 VDD CLK LATCH_SBAR SUB pch W=2.4e-05 L=6e-06
M_LATCH_SET_N0 LATCH_SET_NINT0 CLK VSS SUB nch W=2.4e-05 L=6e-06
M_LATCH_SET_N1 LATCH_SBAR D LATCH_SET_NINT0 SUB nch W=2.4e-05 L=6e-06
M_LATCH_RESET_P0 VDD LATCH_ND LATCH_RBAR SUB pch W=2.4e-05 L=6e-06
M_LATCH_RESET_P1 VDD CLK LATCH_RBAR SUB pch W=2.4e-05 L=6e-06
M_LATCH_RESET_N0 LATCH_RESET_NINT0 CLK VSS SUB nch W=2.4e-05 L=6e-06
M_LATCH_RESET_N1 LATCH_RBAR LATCH_ND LATCH_RESET_NINT0 SUB nch W=2.4e-05 L=6e-06
M_LATCH_LQ_P0 VDD LATCH_SBAR Q SUB pch W=2.4e-05 L=6e-06
M_LATCH_LQ_P1 VDD LATCH_NQ Q SUB pch W=2.4e-05 L=6e-06
M_LATCH_LQ_N0 LATCH_LQ_NINT0 LATCH_NQ VSS SUB nch W=2.4e-05 L=6e-06
M_LATCH_LQ_N1 Q LATCH_SBAR LATCH_LQ_NINT0 SUB nch W=2.4e-05 L=6e-06
M_LATCH_LNQ_P0 VDD LATCH_RBAR LATCH_NQ SUB pch W=2.4e-05 L=6e-06
M_LATCH_LNQ_P1 VDD Q LATCH_NQ SUB pch W=2.4e-05 L=6e-06
M_LATCH_LNQ_N0 LATCH_LNQ_NINT0 Q VSS SUB nch W=2.4e-05 L=6e-06
M_LATCH_LNQ_N1 LATCH_NQ LATCH_RBAR LATCH_LNQ_NINT0 SUB nch W=2.4e-05 L=6e-06
.ENDS LATCH_GATE_X1
.SUBCKT DFF_TG_X1 D CLK Q VDD VSS
M_DFF_CLKINV_P VDD CLK DFF_NCLK SUB pch W=2.4e-05 L=6e-06
M_DFF_CLKINV_N DFF_NCLK CLK VSS SUB nch W=2.4e-05 L=6e-06
M_DFF_MI_N D DFF_NCLK DFF_M1 SUB nch W=2.4e-05 L=6e-06
M_DFF_MI_P D CLK DFF_M1 SUB pch W=2.4e-05 L=6e-06
M_DFF_M0_P VDD DFF_M1 DFF_MQ SUB pch W=2.4e-05 L=6e-06
M_DFF_M0_N DFF_MQ DFF_M1 VSS SUB nch W=2.4e-05 L=6e-06
M_DFF_M1I_P VDD DFF_MQ DFF_M2 SUB pch W=2.4e-05 L=6e-06
M_DFF_M1I_N DFF_M2 DFF_MQ VSS SUB nch W=2.4e-05 L=6e-06
M_DFF_MF_N DFF_M2 CLK DFF_M1 SUB nch W=2.4e-05 L=6e-06
M_DFF_MF_P DFF_M2 DFF_NCLK DFF_M1 SUB pch W=2.4e-05 L=6e-06
M_DFF_SI_N DFF_M2 CLK DFF_S1 SUB nch W=2.4e-05 L=6e-06
M_DFF_SI_P DFF_M2 DFF_NCLK DFF_S1 SUB pch W=2.4e-05 L=6e-06
M_DFF_S0_P VDD DFF_S1 DFF_Q2 SUB pch W=2.4e-05 L=6e-06
M_DFF_S0_N DFF_Q2 DFF_S1 VSS SUB nch W=2.4e-05 L=6e-06
M_DFF_S1I_P VDD DFF_Q2 Q SUB pch W=2.4e-05 L=6e-06
M_DFF_S1I_N Q DFF_Q2 VSS SUB nch W=2.4e-05 L=6e-06
M_DFF_SF_N Q DFF_NCLK DFF_S1 SUB nch W=2.4e-05 L=6e-06
M_DFF_SF_P Q CLK DFF_S1 SUB pch W=2.4e-05 L=6e-06
.ENDS DFF_TG_X1
.SUBCKT DFF_GATE_X1 D CLK Q VDD VSS
M_DFF_GATE_CLKINV_P VDD CLK DFF_GATE_NCLK SUB pch W=2.4e-05 L=6e-06
M_DFF_GATE_CLKINV_N DFF_GATE_NCLK CLK VSS SUB nch W=2.4e-05 L=6e-06
MASTER_DINV_P VDD D MASTER_ND SUB pch W=2.4e-05 L=6e-06
MASTER_DINV_N MASTER_ND D VSS SUB nch W=2.4e-05 L=6e-06
MASTER_SET_P0 VDD D MASTER_SBAR SUB pch W=2.4e-05 L=6e-06
MASTER_SET_P1 VDD DFF_GATE_NCLK MASTER_SBAR SUB pch W=2.4e-05 L=6e-06
MASTER_SET_N0 MASTER_SET_NINT0 DFF_GATE_NCLK VSS SUB nch W=2.4e-05 L=6e-06
MASTER_SET_N1 MASTER_SBAR D MASTER_SET_NINT0 SUB nch W=2.4e-05 L=6e-06
MASTER_RESET_P0 VDD MASTER_ND MASTER_RBAR SUB pch W=2.4e-05 L=6e-06
MASTER_RESET_P1 VDD DFF_GATE_NCLK MASTER_RBAR SUB pch W=2.4e-05 L=6e-06
MASTER_RESET_N0 MASTER_RESET_NINT0 DFF_GATE_NCLK VSS SUB nch W=2.4e-05 L=6e-06
MASTER_RESET_N1 MASTER_RBAR MASTER_ND MASTER_RESET_NINT0 SUB nch W=2.4e-05 L=6e-06
MASTER_LQ_P0 VDD MASTER_SBAR MQ SUB pch W=2.4e-05 L=6e-06
MASTER_LQ_P1 VDD MASTER_NQ MQ SUB pch W=2.4e-05 L=6e-06
MASTER_LQ_N0 MASTER_LQ_NINT0 MASTER_NQ VSS SUB nch W=2.4e-05 L=6e-06
MASTER_LQ_N1 MQ MASTER_SBAR MASTER_LQ_NINT0 SUB nch W=2.4e-05 L=6e-06
MASTER_LNQ_P0 VDD MASTER_RBAR MASTER_NQ SUB pch W=2.4e-05 L=6e-06
MASTER_LNQ_P1 VDD MQ MASTER_NQ SUB pch W=2.4e-05 L=6e-06
MASTER_LNQ_N0 MASTER_LNQ_NINT0 MQ VSS SUB nch W=2.4e-05 L=6e-06
MASTER_LNQ_N1 MASTER_NQ MASTER_RBAR MASTER_LNQ_NINT0 SUB nch W=2.4e-05 L=6e-06
M_SLAVE_DINV_P VDD MQ SLAVE_ND SUB pch W=2.4e-05 L=6e-06
M_SLAVE_DINV_N SLAVE_ND MQ VSS SUB nch W=2.4e-05 L=6e-06
M_SLAVE_SET_P0 VDD MQ SLAVE_SBAR SUB pch W=2.4e-05 L=6e-06
M_SLAVE_SET_P1 VDD CLK SLAVE_SBAR SUB pch W=2.4e-05 L=6e-06
M_SLAVE_SET_N0 SLAVE_SET_NINT0 CLK VSS SUB nch W=2.4e-05 L=6e-06
M_SLAVE_SET_N1 SLAVE_SBAR MQ SLAVE_SET_NINT0 SUB nch W=2.4e-05 L=6e-06
M_SLAVE_RESET_P0 VDD SLAVE_ND SLAVE_RBAR SUB pch W=2.4e-05 L=6e-06
M_SLAVE_RESET_P1 VDD CLK SLAVE_RBAR SUB pch W=2.4e-05 L=6e-06
M_SLAVE_RESET_N0 SLAVE_RESET_NINT0 CLK VSS SUB nch W=2.4e-05 L=6e-06
M_SLAVE_RESET_N1 SLAVE_RBAR SLAVE_ND SLAVE_RESET_NINT0 SUB nch W=2.4e-05 L=6e-06
M_SLAVE_LQ_P0 VDD SLAVE_SBAR Q SUB pch W=2.4e-05 L=6e-06
M_SLAVE_LQ_P1 VDD SLAVE_NQ Q SUB pch W=2.4e-05 L=6e-06
M_SLAVE_LQ_N0 SLAVE_LQ_NINT0 SLAVE_NQ VSS SUB nch W=2.4e-05 L=6e-06
M_SLAVE_LQ_N1 Q SLAVE_SBAR SLAVE_LQ_NINT0 SUB nch W=2.4e-05 L=6e-06
M_SLAVE_LNQ_P0 VDD SLAVE_RBAR SLAVE_NQ SUB pch W=2.4e-05 L=6e-06
M_SLAVE_LNQ_P1 VDD Q SLAVE_NQ SUB pch W=2.4e-05 L=6e-06
M_SLAVE_LNQ_N0 SLAVE_LNQ_NINT0 Q VSS SUB nch W=2.4e-05 L=6e-06
M_SLAVE_LNQ_N1 SLAVE_NQ SLAVE_RBAR SLAVE_LNQ_NINT0 SUB nch W=2.4e-05 L=6e-06
.ENDS DFF_GATE_X1
