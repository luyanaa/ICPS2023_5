* ICPS2023_5 canonical 1M standard-cell reference
.GLOBAL SUB
.SUBCKT AND2_X1 A B Y VDD VSS
M_I_P VDD N Y SUB pch W=2.4e-05 L=6e-06
M_N_P1 VDD B N SUB pch W=2.4e-05 L=6e-06
M_N_P0 VDD A N SUB pch W=2.4e-05 L=6e-06
M_I_N Y N VSS SUB nch W=2.4e-05 L=6e-06
M_N_N0 N_NINT0 B VSS SUB nch W=2.4e-05 L=6e-06
M_N_N1 N A N_NINT0 SUB nch W=2.4e-05 L=6e-06
.ENDS AND2_X1
