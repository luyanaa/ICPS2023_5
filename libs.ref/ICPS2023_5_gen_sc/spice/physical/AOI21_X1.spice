* ICPS2023_5 canonical 1M standard-cell reference
.GLOBAL SUB
.SUBCKT AOI21_X1 A B C Y VDD VSS
M_AOI_PB AOI_PINT B Y SUB pch W=2.4e-05 L=6e-06
M_AOI_PA AOI_PINT A Y SUB pch W=2.4e-05 L=6e-06
M_AOI_PC VDD C AOI_PINT SUB pch W=2.4e-05 L=6e-06
M_AOI_NB AOI_NINT B VSS SUB nch W=2.4e-05 L=6e-06
M_AOI_NC Y C VSS SUB nch W=2.4e-05 L=6e-06
M_AOI_NA Y A AOI_NINT SUB nch W=2.4e-05 L=6e-06
.ENDS AOI21_X1
