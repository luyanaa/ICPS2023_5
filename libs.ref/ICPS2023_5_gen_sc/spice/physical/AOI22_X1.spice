* ICPS2023_5 canonical 1M standard-cell reference
.GLOBAL SUB
.SUBCKT AOI22_X1 A B C D Y VDD VSS
M_AOI_PA VDD A AOI_PINT SUB pch W=2.4e-05 L=6e-06
M_AOI_PB VDD B AOI_PINT SUB pch W=2.4e-05 L=6e-06
M_AOI_PC AOI_PINT C Y SUB pch W=2.4e-05 L=6e-06
M_AOI_PD AOI_PINT D Y SUB pch W=2.4e-05 L=6e-06
M_AOI_NA Y A AOI_NAB SUB nch W=2.4e-05 L=6e-06
M_AOI_NC Y C AOI_NCD SUB nch W=2.4e-05 L=6e-06
M_AOI_ND AOI_NCD D VSS SUB nch W=2.4e-05 L=6e-06
M_AOI_NB AOI_NAB B VSS SUB nch W=2.4e-05 L=6e-06
.ENDS AOI22_X1
