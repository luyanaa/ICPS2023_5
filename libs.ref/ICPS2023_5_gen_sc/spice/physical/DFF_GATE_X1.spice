* ICPS2023_5 canonical 1M standard-cell reference
.GLOBAL SUB
.SUBCKT DFF_GATE_X1 D CLK Q VDD VSS
M_DFF_GATE_CLKINV_P VDD CLK DFF_GATE_NCLK SUB pch W=2.4e-05 L=6e-06
MASTER_DINV_P VDD D MASTER_ND SUB pch W=2.4e-05 L=6e-06
M_SLAVE_SET_P1 VDD CLK SLAVE_SBAR SUB pch W=2.4e-05 L=6e-06
M_SLAVE_SET_P0 VDD MQ SLAVE_SBAR SUB pch W=2.4e-05 L=6e-06
M_SLAVE_RESET_P1 VDD CLK SLAVE_RBAR SUB pch W=2.4e-05 L=6e-06
M_SLAVE_RESET_P0 VDD SLAVE_ND SLAVE_RBAR SUB pch W=2.4e-05 L=6e-06
M_SLAVE_LQ_P1 VDD SLAVE_NQ Q SUB pch W=2.4e-05 L=6e-06
M_SLAVE_LQ_P0 VDD SLAVE_SBAR Q SUB pch W=2.4e-05 L=6e-06
M_SLAVE_LNQ_P1 VDD Q SLAVE_NQ SUB pch W=2.4e-05 L=6e-06
M_SLAVE_LNQ_P0 VDD SLAVE_RBAR SLAVE_NQ SUB pch W=2.4e-05 L=6e-06
MASTER_SET_P1 VDD DFF_GATE_NCLK MASTER_SBAR SUB pch W=2.4e-05 L=6e-06
MASTER_SET_P0 VDD D MASTER_SBAR SUB pch W=2.4e-05 L=6e-06
MASTER_RESET_P1 VDD DFF_GATE_NCLK MASTER_RBAR SUB pch W=2.4e-05 L=6e-06
MASTER_RESET_P0 VDD MASTER_ND MASTER_RBAR SUB pch W=2.4e-05 L=6e-06
MASTER_LQ_P1 VDD MASTER_NQ MQ SUB pch W=2.4e-05 L=6e-06
MASTER_LQ_P0 VDD MASTER_SBAR MQ SUB pch W=2.4e-05 L=6e-06
MASTER_LNQ_P1 VDD MQ MASTER_NQ SUB pch W=2.4e-05 L=6e-06
MASTER_LNQ_P0 VDD MASTER_RBAR MASTER_NQ SUB pch W=2.4e-05 L=6e-06
M_SLAVE_DINV_P VDD MQ SLAVE_ND SUB pch W=2.4e-05 L=6e-06
M_DFF_GATE_CLKINV_N DFF_GATE_NCLK CLK VSS SUB nch W=2.4e-05 L=6e-06
MASTER_DINV_N MASTER_ND D VSS SUB nch W=2.4e-05 L=6e-06
MASTER_RESET_N1 MASTER_RBAR MASTER_ND MASTER_RESET_NINT0 SUB nch W=2.4e-05 L=6e-06
MASTER_RESET_N0 MASTER_RESET_NINT0 DFF_GATE_NCLK VSS SUB nch W=2.4e-05 L=6e-06
MASTER_SET_N0 MASTER_SET_NINT0 DFF_GATE_NCLK VSS SUB nch W=2.4e-05 L=6e-06
MASTER_SET_N1 MASTER_SBAR D MASTER_SET_NINT0 SUB nch W=2.4e-05 L=6e-06
MASTER_LQ_N0 MASTER_LQ_NINT0 MASTER_NQ VSS SUB nch W=2.4e-05 L=6e-06
MASTER_LQ_N1 MQ MASTER_SBAR MASTER_LQ_NINT0 SUB nch W=2.4e-05 L=6e-06
MASTER_LNQ_N1 MASTER_NQ MASTER_RBAR MASTER_LNQ_NINT0 SUB nch W=2.4e-05 L=6e-06
MASTER_LNQ_N0 MASTER_LNQ_NINT0 MQ VSS SUB nch W=2.4e-05 L=6e-06
M_SLAVE_SET_N0 SLAVE_SET_NINT0 CLK VSS SUB nch W=2.4e-05 L=6e-06
M_SLAVE_SET_N1 SLAVE_SBAR MQ SLAVE_SET_NINT0 SUB nch W=2.4e-05 L=6e-06
M_SLAVE_LQ_N1 Q SLAVE_SBAR SLAVE_LQ_NINT0 SUB nch W=2.4e-05 L=6e-06
M_SLAVE_LQ_N0 SLAVE_LQ_NINT0 SLAVE_NQ VSS SUB nch W=2.4e-05 L=6e-06
M_SLAVE_DINV_N SLAVE_ND MQ VSS SUB nch W=2.4e-05 L=6e-06
M_SLAVE_LNQ_N1 SLAVE_NQ SLAVE_RBAR SLAVE_LNQ_NINT0 SUB nch W=2.4e-05 L=6e-06
M_SLAVE_LNQ_N0 SLAVE_LNQ_NINT0 Q VSS SUB nch W=2.4e-05 L=6e-06
M_SLAVE_RESET_N0 SLAVE_RESET_NINT0 CLK VSS SUB nch W=2.4e-05 L=6e-06
M_SLAVE_RESET_N1 SLAVE_RBAR SLAVE_ND SLAVE_RESET_NINT0 SUB nch W=2.4e-05 L=6e-06
.ENDS DFF_GATE_X1
