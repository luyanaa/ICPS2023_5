* ICPS2023_5 canonical 1M standard-cell reference
.GLOBAL SUB
.SUBCKT DFF_TG_X1 D CLK Q VDD VSS
M_DFF_MI_P D CLK DFF_M1 SUB pch W=2.4e-05 L=6e-06
M_DFF_MF_P DFF_M2 DFF_NCLK DFF_M1 SUB pch W=2.4e-05 L=6e-06
M_DFF_M1I_P VDD DFF_MQ DFF_M2 SUB pch W=2.4e-05 L=6e-06
M_DFF_CLKINV_P VDD CLK DFF_NCLK SUB pch W=2.4e-05 L=6e-06
M_DFF_M0_P VDD DFF_M1 DFF_MQ SUB pch W=2.4e-05 L=6e-06
M_DFF_S1I_P VDD DFF_Q2 Q SUB pch W=2.4e-05 L=6e-06
M_DFF_SF_P Q CLK DFF_S1 SUB pch W=2.4e-05 L=6e-06
M_DFF_SI_P DFF_M2 DFF_NCLK DFF_S1 SUB pch W=2.4e-05 L=6e-06
M_DFF_S0_P VDD DFF_S1 DFF_Q2 SUB pch W=2.4e-05 L=6e-06
M_DFF_MI_N D DFF_NCLK DFF_M1 SUB nch W=2.4e-05 L=6e-06
M_DFF_MF_N DFF_M2 CLK DFF_M1 SUB nch W=2.4e-05 L=6e-06
M_DFF_M1I_N DFF_M2 DFF_MQ VSS SUB nch W=2.4e-05 L=6e-06
M_DFF_CLKINV_N DFF_NCLK CLK VSS SUB nch W=2.4e-05 L=6e-06
M_DFF_M0_N DFF_MQ DFF_M1 VSS SUB nch W=2.4e-05 L=6e-06
M_DFF_S1I_N Q DFF_Q2 VSS SUB nch W=2.4e-05 L=6e-06
M_DFF_SF_N Q DFF_NCLK DFF_S1 SUB nch W=2.4e-05 L=6e-06
M_DFF_SI_N DFF_M2 CLK DFF_S1 SUB nch W=2.4e-05 L=6e-06
M_DFF_S0_N DFF_Q2 DFF_S1 VSS SUB nch W=2.4e-05 L=6e-06
.ENDS DFF_TG_X1
