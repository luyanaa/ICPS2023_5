* ICPS2023_5 canonical 1M standard-cell reference
.GLOBAL SUB
.SUBCKT FA_X1 A B CIN SUM COUT VDD VSS
M_X0_IB_P VDD B X0_NB SUB pch W=2.4e-05 L=6e-06
M_X0_PA VDD A X0_P0 SUB pch W=2.4e-05 L=6e-06
M_X0_PNB X0_P0 X0_NB XAB SUB pch W=2.4e-05 L=6e-06
M_X0_PB X0_P1 B XAB SUB pch W=2.4e-05 L=6e-06
M_X0_PNA VDD X0_NA X0_P1 SUB pch W=2.4e-05 L=6e-06
M_X1_IA_P VDD XAB X1_NA SUB pch W=2.4e-05 L=6e-06
M_X0_IA_P VDD A X0_NA SUB pch W=2.4e-05 L=6e-06
M_C1_P1 VDD XAB N1 SUB pch W=2.4e-05 L=6e-06
M_C1_P0 VDD CIN N1 SUB pch W=2.4e-05 L=6e-06
M_C0_P1 VDD B N0 SUB pch W=2.4e-05 L=6e-06
M_C0_P0 VDD A N0 SUB pch W=2.4e-05 L=6e-06
M_CO_P0 VDD N0 COUT SUB pch W=2.4e-05 L=6e-06
M_CO_P1 VDD N1 COUT SUB pch W=2.4e-05 L=6e-06
M_X1_PNA VDD X1_NA X1_P1 SUB pch W=2.4e-05 L=6e-06
M_X1_PB X1_P1 CIN SUM SUB pch W=2.4e-05 L=6e-06
M_X1_PNB X1_P0 X1_NB SUM SUB pch W=2.4e-05 L=6e-06
M_X1_PA VDD XAB X1_P0 SUB pch W=2.4e-05 L=6e-06
M_X1_IB_P VDD CIN X1_NB SUB pch W=2.4e-05 L=6e-06
M_C0_N1 N0 A C0_NINT0 SUB nch W=2.4e-05 L=6e-06
M_CO_N1 COUT N0 CO_NINT0 SUB nch W=2.4e-05 L=6e-06
M_CO_N0 CO_NINT0 N1 VSS SUB nch W=2.4e-05 L=6e-06
M_X0_IA_N X0_NA A VSS SUB nch W=2.4e-05 L=6e-06
M_C0_N0 C0_NINT0 B VSS SUB nch W=2.4e-05 L=6e-06
M_C1_N0 C1_NINT0 XAB VSS SUB nch W=2.4e-05 L=6e-06
M_C1_N1 N1 CIN C1_NINT0 SUB nch W=2.4e-05 L=6e-06
M_X0_IB_N X0_NB B VSS SUB nch W=2.4e-05 L=6e-06
M_X1_IA_N X1_NA XAB VSS SUB nch W=2.4e-05 L=6e-06
M_X0_NB X0_N0 B VSS SUB nch W=2.4e-05 L=6e-06
M_X0_NA XAB A X0_N0 SUB nch W=2.4e-05 L=6e-06
M_X0_NNA XAB X0_NA X0_N1 SUB nch W=2.4e-05 L=6e-06
M_X0_NNB X0_N1 X0_NB VSS SUB nch W=2.4e-05 L=6e-06
M_X1_NB X1_N0 CIN VSS SUB nch W=2.4e-05 L=6e-06
M_X1_NA SUM XAB X1_N0 SUB nch W=2.4e-05 L=6e-06
M_X1_NNA SUM X1_NA X1_N1 SUB nch W=2.4e-05 L=6e-06
M_X1_NNB X1_N1 X1_NB VSS SUB nch W=2.4e-05 L=6e-06
M_X1_IB_N X1_NB CIN VSS SUB nch W=2.4e-05 L=6e-06
.ENDS FA_X1
