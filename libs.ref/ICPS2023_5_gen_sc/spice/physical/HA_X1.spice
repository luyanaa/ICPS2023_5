* ICPS2023_5 canonical 1M standard-cell reference
.GLOBAL SUB
.SUBCKT HA_X1 A B SUM COUT VDD VSS
M_CARRYI_P VDD NC COUT SUB pch W=2.4e-05 L=6e-06
M_CARRY_P0 VDD A NC SUB pch W=2.4e-05 L=6e-06
M_CARRY_P1 VDD B NC SUB pch W=2.4e-05 L=6e-06
M_SUM_IA_P VDD A SUM_NA SUB pch W=2.4e-05 L=6e-06
M_SUM_PNA VDD SUM_NA SUM_P1 SUB pch W=2.4e-05 L=6e-06
M_SUM_PB SUM_P1 B SUM SUB pch W=2.4e-05 L=6e-06
M_SUM_PNB SUM_P0 SUM_NB SUM SUB pch W=2.4e-05 L=6e-06
M_SUM_PA VDD A SUM_P0 SUB pch W=2.4e-05 L=6e-06
M_SUM_IB_P VDD B SUM_NB SUB pch W=2.4e-05 L=6e-06
M_CARRYI_N COUT NC VSS SUB nch W=2.4e-05 L=6e-06
M_CARRY_N0 CARRY_NINT0 B VSS SUB nch W=2.4e-05 L=6e-06
M_CARRY_N1 NC A CARRY_NINT0 SUB nch W=2.4e-05 L=6e-06
M_SUM_IA_N SUM_NA A VSS SUB nch W=2.4e-05 L=6e-06
M_SUM_NB SUM_N0 B VSS SUB nch W=2.4e-05 L=6e-06
M_SUM_NA SUM A SUM_N0 SUB nch W=2.4e-05 L=6e-06
M_SUM_NNA SUM SUM_NA SUM_N1 SUB nch W=2.4e-05 L=6e-06
M_SUM_NNB SUM_N1 SUM_NB VSS SUB nch W=2.4e-05 L=6e-06
M_SUM_IB_N SUM_NB B VSS SUB nch W=2.4e-05 L=6e-06
.ENDS HA_X1
