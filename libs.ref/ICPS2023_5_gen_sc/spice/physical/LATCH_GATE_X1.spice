* ICPS2023_5 canonical 1M standard-cell reference
.GLOBAL SUB
.SUBCKT LATCH_GATE_X1 D CLK Q VDD VSS
M_LATCH_DINV_P VDD D LATCH_ND SUB pch W=2.4e-05 L=6e-06
M_LATCH_LNQ_P0 VDD LATCH_RBAR LATCH_NQ SUB pch W=2.4e-05 L=6e-06
M_LATCH_LNQ_P1 VDD Q LATCH_NQ SUB pch W=2.4e-05 L=6e-06
M_LATCH_LQ_P0 VDD LATCH_SBAR Q SUB pch W=2.4e-05 L=6e-06
M_LATCH_LQ_P1 VDD LATCH_NQ Q SUB pch W=2.4e-05 L=6e-06
M_LATCH_RESET_P0 VDD LATCH_ND LATCH_RBAR SUB pch W=2.4e-05 L=6e-06
M_LATCH_RESET_P1 VDD CLK LATCH_RBAR SUB pch W=2.4e-05 L=6e-06
M_LATCH_SET_P0 VDD D LATCH_SBAR SUB pch W=2.4e-05 L=6e-06
M_LATCH_SET_P1 VDD CLK LATCH_SBAR SUB pch W=2.4e-05 L=6e-06
M_LATCH_LNQ_N1 LATCH_NQ LATCH_RBAR LATCH_LNQ_NINT0 SUB nch W=2.4e-05 L=6e-06
M_LATCH_RESET_N1 LATCH_RBAR LATCH_ND LATCH_RESET_NINT0 SUB nch W=2.4e-05 L=6e-06
M_LATCH_RESET_N0 LATCH_RESET_NINT0 CLK VSS SUB nch W=2.4e-05 L=6e-06
M_LATCH_LQ_N0 LATCH_LQ_NINT0 LATCH_NQ VSS SUB nch W=2.4e-05 L=6e-06
M_LATCH_LQ_N1 Q LATCH_SBAR LATCH_LQ_NINT0 SUB nch W=2.4e-05 L=6e-06
M_LATCH_LNQ_N0 LATCH_LNQ_NINT0 Q VSS SUB nch W=2.4e-05 L=6e-06
M_LATCH_DINV_N LATCH_ND D VSS SUB nch W=2.4e-05 L=6e-06
M_LATCH_SET_N0 LATCH_SET_NINT0 CLK VSS SUB nch W=2.4e-05 L=6e-06
M_LATCH_SET_N1 LATCH_SBAR D LATCH_SET_NINT0 SUB nch W=2.4e-05 L=6e-06
.ENDS LATCH_GATE_X1
