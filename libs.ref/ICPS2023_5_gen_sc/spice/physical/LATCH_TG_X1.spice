* ICPS2023_5 canonical 1M standard-cell reference
.GLOBAL SUB
.SUBCKT LATCH_TG_X1 D CLK Q VDD VSS
M_LATCH_INV0_P VDD LATCH_N1 LATCH_N2 SUB pch W=2.4e-05 L=6e-06
M_LATCH_CLKINV_P VDD CLK LATCH_NCLK SUB pch W=2.4e-05 L=6e-06
M_LATCH_INV1_P VDD LATCH_N2 Q SUB pch W=2.4e-05 L=6e-06
M_LATCH_FB_P Q CLK LATCH_N1 SUB pch W=2.4e-05 L=6e-06
M_LATCH_IN_P D LATCH_NCLK LATCH_N1 SUB pch W=2.4e-05 L=6e-06
M_LATCH_INV0_N LATCH_N2 LATCH_N1 VSS SUB nch W=2.4e-05 L=6e-06
M_LATCH_CLKINV_N LATCH_NCLK CLK VSS SUB nch W=2.4e-05 L=6e-06
M_LATCH_INV1_N Q LATCH_N2 VSS SUB nch W=2.4e-05 L=6e-06
M_LATCH_FB_N Q LATCH_NCLK LATCH_N1 SUB nch W=2.4e-05 L=6e-06
M_LATCH_IN_N D CLK LATCH_N1 SUB nch W=2.4e-05 L=6e-06
.ENDS LATCH_TG_X1
