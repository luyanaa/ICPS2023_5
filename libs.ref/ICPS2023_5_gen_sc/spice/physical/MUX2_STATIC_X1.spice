* ICPS2023_5 canonical 1M standard-cell reference
.GLOBAL SUB
.SUBCKT MUX2_STATIC_X1 A B S Y VDD VSS
MUX_N2_P1 VDD MUX_T1 Y SUB pch W=2.4e-05 L=6e-06
MUX_N2_P0 VDD MUX_T0 Y SUB pch W=2.4e-05 L=6e-06
MUX_N1_P1 VDD MUX_NS MUX_T1 SUB pch W=2.4e-05 L=6e-06
MUX_N1_P0 VDD B MUX_T1 SUB pch W=2.4e-05 L=6e-06
MUX_N0_P1 VDD S MUX_T0 SUB pch W=2.4e-05 L=6e-06
MUX_N0_P0 VDD A MUX_T0 SUB pch W=2.4e-05 L=6e-06
MUX_SELINV_P VDD S MUX_NS SUB pch W=2.4e-05 L=6e-06
MUX_N0_N1 MUX_T0 A MUX_N0_NINT0 SUB nch W=2.4e-05 L=6e-06
MUX_N2_N1 Y MUX_T0 MUX_N2_NINT0 SUB nch W=2.4e-05 L=6e-06
MUX_N2_N0 MUX_N2_NINT0 MUX_T1 VSS SUB nch W=2.4e-05 L=6e-06
MUX_SELINV_N MUX_NS S VSS SUB nch W=2.4e-05 L=6e-06
MUX_N0_N0 MUX_N0_NINT0 S VSS SUB nch W=2.4e-05 L=6e-06
MUX_N1_N0 MUX_N1_NINT0 MUX_NS VSS SUB nch W=2.4e-05 L=6e-06
MUX_N1_N1 MUX_T1 B MUX_N1_NINT0 SUB nch W=2.4e-05 L=6e-06
.ENDS MUX2_STATIC_X1
