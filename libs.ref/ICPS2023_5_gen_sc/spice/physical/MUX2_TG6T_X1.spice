* ICPS2023_5 canonical 1M standard-cell reference
.GLOBAL SUB
.SUBCKT MUX2_TG6T_X1 A B S Y VDD VSS
MUX_A_P A MUX_NS Y SUB pch W=2.4e-05 L=6e-06
MUX_B_P B S Y SUB pch W=2.4e-05 L=6e-06
MUX_SELINV_P VDD S MUX_NS SUB pch W=2.4e-05 L=6e-06
MUX_A_N A S Y SUB nch W=2.4e-05 L=6e-06
MUX_B_N B MUX_NS Y SUB nch W=2.4e-05 L=6e-06
MUX_SELINV_N MUX_NS S VSS SUB nch W=2.4e-05 L=6e-06
.ENDS MUX2_TG6T_X1
