* ICPS2023_5 canonical 1M standard-cell reference
.GLOBAL SUB
.SUBCKT NAND2_BA_X1 B A Y VDD VSS
M_NAND_P0 VDD B Y SUB pch W=2.4e-05 L=6e-06
M_NAND_P1 VDD A Y SUB pch W=2.4e-05 L=6e-06
M_NAND_N0 NAND_NINT0 A VSS SUB nch W=2.4e-05 L=6e-06
M_NAND_N1 Y B NAND_NINT0 SUB nch W=2.4e-05 L=6e-06
.ENDS NAND2_BA_X1
