* ICPS2023_5 canonical 1M standard-cell reference
.GLOBAL SUB
.SUBCKT NAND2_X1 A B Y VDD VSS
M_NAND_P0 VDD A Y SUB pch W=2.4e-05 L=6e-06
M_NAND_P1 VDD B Y SUB pch W=2.4e-05 L=6e-06
M_NAND_N0 NAND_NINT0 B VSS SUB nch W=2.4e-05 L=6e-06
M_NAND_N1 Y A NAND_NINT0 SUB nch W=2.4e-05 L=6e-06
.ENDS NAND2_X1
