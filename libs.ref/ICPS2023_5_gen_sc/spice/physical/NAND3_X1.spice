* ICPS2023_5 canonical 1M standard-cell reference
.GLOBAL SUB
.SUBCKT NAND3_X1 A B C Y VDD VSS
M_NAND_P2 VDD C Y SUB pch W=2.4e-05 L=6e-06
M_NAND_P1 VDD B Y SUB pch W=2.4e-05 L=6e-06
M_NAND_P0 VDD A Y SUB pch W=2.4e-05 L=6e-06
M_NAND_N0 NAND_NINT0 C VSS SUB nch W=2.4e-05 L=6e-06
M_NAND_N1 NAND_NINT1 B NAND_NINT0 SUB nch W=2.4e-05 L=6e-06
M_NAND_N2 Y A NAND_NINT1 SUB nch W=2.4e-05 L=6e-06
.ENDS NAND3_X1
