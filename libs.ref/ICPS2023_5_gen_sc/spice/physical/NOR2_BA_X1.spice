* ICPS2023_5 canonical 1M standard-cell reference
.GLOBAL SUB
.SUBCKT NOR2_BA_X1 B A Y VDD VSS
M_NOR_P0 NOR_PINT0 B Y SUB pch W=2.4e-05 L=6e-06
M_NOR_P1 VDD A NOR_PINT0 SUB pch W=2.4e-05 L=6e-06
M_NOR_N0 Y B VSS SUB nch W=2.4e-05 L=6e-06
M_NOR_N1 Y A VSS SUB nch W=2.4e-05 L=6e-06
.ENDS NOR2_BA_X1
