* ICPS2023_5 canonical 1M standard-cell reference
.GLOBAL SUB
.SUBCKT NOR2_X1 A B Y VDD VSS
M_NOR_P0 NOR_PINT0 A Y SUB pch W=2.4e-05 L=6e-06
M_NOR_P1 VDD B NOR_PINT0 SUB pch W=2.4e-05 L=6e-06
M_NOR_N0 Y A VSS SUB nch W=2.4e-05 L=6e-06
M_NOR_N1 Y B VSS SUB nch W=2.4e-05 L=6e-06
.ENDS NOR2_X1
