* ICPS2023_5 canonical 1M standard-cell reference
.GLOBAL SUB
.SUBCKT NOR3_X1 A B C Y VDD VSS
M_NOR_P0 NOR_PINT0 A Y SUB pch W=2.4e-05 L=6e-06
M_NOR_P1 NOR_PINT1 B NOR_PINT0 SUB pch W=2.4e-05 L=6e-06
M_NOR_P2 VDD C NOR_PINT1 SUB pch W=2.4e-05 L=6e-06
M_NOR_N0 Y A VSS SUB nch W=2.4e-05 L=6e-06
M_NOR_N1 Y B VSS SUB nch W=2.4e-05 L=6e-06
M_NOR_N2 Y C VSS SUB nch W=2.4e-05 L=6e-06
.ENDS NOR3_X1
