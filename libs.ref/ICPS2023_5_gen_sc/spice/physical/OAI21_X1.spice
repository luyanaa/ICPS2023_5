* ICPS2023_5 canonical 1M standard-cell reference
.GLOBAL SUB
.SUBCKT OAI21_X1 A B C Y VDD VSS
M_OAI_PA Y A OAI_PINT SUB pch W=2.4e-05 L=6e-06
M_OAI_PC VDD C Y SUB pch W=2.4e-05 L=6e-06
M_OAI_PB OAI_PINT B VDD SUB pch W=2.4e-05 L=6e-06
M_OAI_NA OAI_NINT A VSS SUB nch W=2.4e-05 L=6e-06
M_OAI_NB OAI_NINT B VSS SUB nch W=2.4e-05 L=6e-06
M_OAI_NC Y C OAI_NINT SUB nch W=2.4e-05 L=6e-06
.ENDS OAI21_X1
