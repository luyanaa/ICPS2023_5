* ICPS2023_5 canonical 1M standard-cell reference
.GLOBAL SUB
.SUBCKT OAI22_X1 A B C D Y VDD VSS
M_OAI_PA VDD A OAI_PAB SUB pch W=2.4e-05 L=6e-06
M_OAI_PC VDD C OAI_PCD SUB pch W=2.4e-05 L=6e-06
M_OAI_PD OAI_PCD D Y SUB pch W=2.4e-05 L=6e-06
M_OAI_PB OAI_PAB B Y SUB pch W=2.4e-05 L=6e-06
M_OAI_NA Y A OAI_NINT SUB nch W=2.4e-05 L=6e-06
M_OAI_NB Y B OAI_NINT SUB nch W=2.4e-05 L=6e-06
M_OAI_NC OAI_NINT C VSS SUB nch W=2.4e-05 L=6e-06
M_OAI_ND OAI_NINT D VSS SUB nch W=2.4e-05 L=6e-06
.ENDS OAI22_X1
