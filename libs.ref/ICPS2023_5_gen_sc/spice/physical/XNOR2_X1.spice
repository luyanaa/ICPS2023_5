* ICPS2023_5 canonical 1M standard-cell reference
.GLOBAL SUB
.SUBCKT XNOR2_X1 A B Y VDD VSS
M_XNOR_IA_P VDD A XNOR_NA SUB pch W=2.4e-05 L=6e-06
M_XNOR_PA VDD A XNOR_P0 SUB pch W=2.4e-05 L=6e-06
M_XNOR_PB XNOR_P0 B Y SUB pch W=2.4e-05 L=6e-06
M_XNOR_PNB XNOR_P1 XNOR_NB Y SUB pch W=2.4e-05 L=6e-06
M_XNOR_PNA VDD XNOR_NA XNOR_P1 SUB pch W=2.4e-05 L=6e-06
M_XNOR_IB_P VDD B XNOR_NB SUB pch W=2.4e-05 L=6e-06
M_XNOR_IA_N XNOR_NA A VSS SUB nch W=2.4e-05 L=6e-06
M_XNOR_NB XNOR_N0 XNOR_NB VSS SUB nch W=2.4e-05 L=6e-06
M_XNOR_NA Y A XNOR_N0 SUB nch W=2.4e-05 L=6e-06
M_XNOR_NNA Y XNOR_NA XNOR_N1 SUB nch W=2.4e-05 L=6e-06
M_XNOR_NNB XNOR_N1 B VSS SUB nch W=2.4e-05 L=6e-06
M_XNOR_IB_N XNOR_NB B VSS SUB nch W=2.4e-05 L=6e-06
.ENDS XNOR2_X1
