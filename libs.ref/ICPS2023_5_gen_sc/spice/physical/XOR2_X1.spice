* ICPS2023_5 canonical 1M standard-cell reference
.GLOBAL SUB
.SUBCKT XOR2_X1 A B Y VDD VSS
M_XOR_IA_P VDD A XOR_NA SUB pch W=2.4e-05 L=6e-06
M_XOR_PA VDD A XOR_P0 SUB pch W=2.4e-05 L=6e-06
M_XOR_PNB XOR_P0 XOR_NB Y SUB pch W=2.4e-05 L=6e-06
M_XOR_PB XOR_P1 B Y SUB pch W=2.4e-05 L=6e-06
M_XOR_PNA VDD XOR_NA XOR_P1 SUB pch W=2.4e-05 L=6e-06
M_XOR_IB_P VDD B XOR_NB SUB pch W=2.4e-05 L=6e-06
M_XOR_IA_N XOR_NA A VSS SUB nch W=2.4e-05 L=6e-06
M_XOR_NB XOR_N0 B VSS SUB nch W=2.4e-05 L=6e-06
M_XOR_NA Y A XOR_N0 SUB nch W=2.4e-05 L=6e-06
M_XOR_NNA Y XOR_NA XOR_N1 SUB nch W=2.4e-05 L=6e-06
M_XOR_NNB XOR_N1 XOR_NB VSS SUB nch W=2.4e-05 L=6e-06
M_XOR_IB_N XOR_NB B VSS SUB nch W=2.4e-05 L=6e-06
.ENDS XOR2_X1
