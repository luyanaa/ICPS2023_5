* Bridge-candidate library selector for the experimental ideal-FD card.
* Mirrors icps2023_5.lib.spice's b4soi section but selects the bridge card
* generated by tools/fit_b4soi_bridge.py (SOIMOD=2, NCH=1.0e15, NGATE=0).
*
* ENGINE SCOPE: Xyce 7.10 / BSIMSOI 4.5.0, W24/L6, 3 V, 25 C, 4-terminal
* D/G/S/E only.  The card carries the ngspice LEVEL=58 token; Xyce requires
* the ported LEVEL=70450 form (libs.tech/ngspice/tools/xyce_b4soi.py,
* port_card()).  ngspice BSIMSOI 4.4 shows a documented 5-11 %
* strong-inversion divergence and must not accept this card or be mixed with
* it (AGENTS.md 1.2).  libs.tech/stdcell/verify.py materialises the ported
* card next to each assembled postlayout netlist.
*
* This is NOT the nominal PDK selector: icps2023_5.lib.spice with
* models/icps2023_5_b4soi.inc (stage-1, SOIMOD=0) remains nominal.
*
* Paths are relative to this file; ngspice and Xyce both resolve nested
* includes against the including file's directory.
.lib b4soi
.include models/b4soi_fd_bridge_experimental.inc
.endl b4soi
